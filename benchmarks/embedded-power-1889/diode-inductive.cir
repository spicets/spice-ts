Diode clamped inductive load original MIT circuit
Vdd supply 0 5
Vdrive gate 0 PULSE(0 3.3 1u 10n 10n 8u 20u)
Rcoil supply coil 20
Lcoil coil out 470u
Dfly out supply DF
M1 out gate 0 0 NM
.model DF D(IS=1e-12)
.model NM NMOS (LEVEL=1 VTO=1 KP=0.01)
.tran 100n 60u
.end
