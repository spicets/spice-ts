Ideal switch buck converter original MIT circuit
Vdd supply 0 5
Vdrive ctrl 0 PULSE(0 3.3 1u 10n 10n 5u 10u)
S1 supply sw ctrl 0 SWMOD
D1 0 sw DF
L1 sw out 100u
C1 out 0 10u
Rload out 0 100
.model SWMOD SW(RON=0.1 ROFF=1Meg VT=1.65 VH=0)
.model DF D(IS=1e-12)
.tran 100n 50u
.end
