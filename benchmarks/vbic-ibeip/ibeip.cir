VBIC parasitic BE current probe (project-authored MIT)
VC c 0 0.1
VB b 0 DC 0.65 AC 1
VS s 0 0
Q1 c b 0 s QV
.model QV NPN(LEVEL=4 IS=1e-16 IBEIP=1e-12 IBENP=2e-10 NCI=1.2 NCN=1.8 NEI=1.1 NEN=2.2 RBP=500 RBX=20 RBI=1000)
.temp 75
.op
.dc VB 0.6 0.7 0.05
.ac dec 1 1meg 100meg
.save i(vc) i(vb) i(vs)
.end
