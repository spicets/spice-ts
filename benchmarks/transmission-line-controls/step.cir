Lossless T-line breakpoint controls regression (#1504)
VSTEP source 0 PULSE(0 1 1n 100p 100p 100n 200n)
RS source input 25
T1 input 0 output 0 Z0=50 TD=5n
RL output 0 100
.tran 50p 20n 0 50p
.end
