filesource defaults (self-authored MIT)
a1 %v([out]) src
.model src filesource(file="table.txt" amploffset=[0] amplscale=[1])
r1 out 0 1k
.tran 10u 800u
.end
