oracle
.control
set numdgt=17
source input.cir
run
wrdata reference.txt v(out)
quit
.endc
.end
