* t
YGENEXT g1 a b osdimod
V1 a 0 1
R1 b 0 1k
.op
.end
