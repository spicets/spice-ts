Self-authored BSIM4 NMOS inversion gate-body sweep (MIT)
.model DUT NMOS LEVEL=54 VERSION=4.8 IGBMOD=1 TOXE=1n TOXREF=1.2n NTOX=1.3
Vd d 0 0.7
Vg g 0 0
Vb b 0 -0.2
M1 d g 0 b DUT L=100n W=10u NF=3 M=2
.temp 27
.save v(g) i(Vg) i(Vb) @m1[igb]
.dc Vg 0.5 2 0.05
.print dc i(Vg) i(Vb) @m1[igb]
.end
