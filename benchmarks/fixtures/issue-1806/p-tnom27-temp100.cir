MOS6 circuit temperature p-tnom27-temp100
VD supply 0 -3
VG g 0 -2
VB b 0 0.4
RD supply d 1k
RS s 0 100
M1 d g s b MOD L=2u W=10u AD=2p AS=3p
.model MOD PMOS LEVEL=6 VTO=-0.7 KV=1.2 NV=0.9 KC=50u NC=1.3 GAMMA=0.4 GAMMA1=0.05 SIGMA=0.02 LAMBDA0=0.02 LAMBDA1=0.004 PHI=0.6 IS=1e-14 JS=1e-8 TNOM=27
.options TEMP=100 RELTOL=1e-10 ABSTOL=1e-15 VNTOL=1e-12
.op
.dc VG -0.8 -2.4 -0.4
.control
set filetype=ascii
.endc
.end
