MOS6 instance temperature n-both
Vd supply 0 3
Vg g 0 2
Vb b 0 -0.4
Rd supply d 1k
Rs s 0 100
M1 d g s b MOD L=2u W=10u AD=2p AS=3p TEMP=75 DTEMP=30
.model MOD NMOS LEVEL=6 VTO=0.7 KV=1.2 NV=0.9 KC=50u NC=1.3 GAMMA=0.4 GAMMA1=0.05 SIGMA=0.02 LAMBDA0=0.02 LAMBDA1=0.004 PHI=0.6 IS=1e-14 JS=1e-8 TNOM=27
.options TEMP=40 RELTOL=1e-10 ABSTOL=1e-15 VNTOL=1e-12
.op
.dc Vg 0 3 0.05
.control
set filetype=ascii
.endc
.end
