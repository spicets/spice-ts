BSIM circuit temperature b1-n-model75-temp-20
VD supply 0 3
VG g 0 2
VB b 0 -0.4
RD supply d 1k
RS s 0 100
M1 d g s b MOD L=5u W=20u AD=2p AS=3p PD=6u PS=8u
.model MOD NMOS LEVEL=4 TOX=0.03 VFB=-1 PHI=0.8 K1=1.3 MUZ=600 MUS=600 U0=0.05 N0=1.4 JS=1e-4 PB=0.8 PBSW=0.7 CJ=1e-4 CJSW=1e-10 TEMP=75
.options TEMP=-20 RELTOL=1e-10 ABSTOL=1e-15 VNTOL=1e-12
.op
.dc VG 0.4 2.4 0.4
.control
set filetype=ascii
.endc
.end
