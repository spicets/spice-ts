Self-heating diode AC both-caps (project-authored MIT)
Vsrc in 0 DC 0.8 AC 1
Rbias in anode 10
D1 anode 0 tj DM thermal
.model DM D(IS=1e-14 RTH0=100 CTH0=10u CJO=10n TNOM=27)
.options reltol=1e-10 abstol=1e-14 vntol=1e-12
.ac dec 10 1 1e6
.end
