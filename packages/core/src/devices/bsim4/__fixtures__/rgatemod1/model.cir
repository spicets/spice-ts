Authored BSIM4 RGATEMOD=1 OP/DC regression (MIT)
.model DUT NMOS LEVEL=54 VERSION=4.8.3 IGCMOD=1 IGBMOD=1 TOXE=1n RGATEMOD=1 RSHG=1meg XGW=20n XGL=10n NGCON=2
Vd d 0 0.7
Vg g 0 1.4
Vb b 0 -0.2
Vs s 0 0
M1 d g s b DUT L=1u W=10u NF=2 M=3
.options abstol=1e-15 reltol=1e-10 vntol=1e-12
.op
.dc Vg 0.8 1.6 0.2
.end
