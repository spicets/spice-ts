Original MIT BSIM4 LOD OP/DC regression
.model DUT NMOS LEVEL=54 VERSION=4.8 KU0=1e-7 KVTH0=2e-8 KVSAT=0.4 STK2=1e-8 STETA0=2e-8 WLOD=0.1u LLODKU0=1 WLODKU0=1 LKU0=0.2u WKU0=0.1u PKU0=0.01p LLODVTH=1 WLODVTH=1 LKVTH0=0.1u WKVTH0=0.2u PKVTH0=0.02p TKU0=0.2 LODK2=1.2 LODETA0=0.8
Vd d 0 0.8
Vg g 0 1.2
Vs s 0 0
Vb b 0 -0.2
M1 d g s b DUT L=1u W=10u SA=0.5u SB=0.7u SD=0.2u NF=3 MULU0=1.2 DELVTO=0.03
.temp 75
.options abstol=1e-15 reltol=1e-10 vntol=1e-12
.save v(d) v(g) v(s) v(b) i(Vd)
.op
.dc Vg 0.4 1.4 0.2
.end
