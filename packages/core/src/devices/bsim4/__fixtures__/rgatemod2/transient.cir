Authored BSIM4 RGATEMOD=2 common-source transient regression (MIT)
.model DUT NMOS LEVEL=54 VERSION=4.8.3 RGATEMOD=2 RSHG=1000
Vdd vdd 0 1.8
Rd vdd out 10k
Vin in 0 PULSE(0 1.2 10n 10n 10n 80n 200n)
M1 out in 0 0 DUT L=1u W=10u
Cl out 0 100f
.tran 1n 200n
.end
