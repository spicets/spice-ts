RC temperature coefficients at 100 C
V1 in 0 DC 0 AC 1 PULSE(0 1 0 1n 1n 10m 20m)
R1 in out 1k
C1 out 0 1u TC1=1e-3 TC2=1e-5
.options TEMP=100 reltol=1e-9 abstol=1e-14 vntol=1e-12
.ac lin 1 141.305731139 141.305731139
.tran 1u 2m 0 1u
.save v(in) v(out) i(v1)
.end
